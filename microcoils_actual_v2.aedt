# Ansys Electronics Desktop project, version 2023.2
materials:
  vacuum: permittivity=1
  titanium: permeability=1.00018 conductivity=1820000
  diamond_pl_cvd: permittivity=3.5
  air: permittivity=1.0006 permeability=1.0000004
  gold: permeability=0.99996 conductivity=41000000
  diamond: permittivity=16.5

design HFSSDesign1 (HFSS, HFSS Terminal Network, model units mm)
geometry:
  point id35 = (0mm, 0mm, 0mm)
  id26 = imported_body(I:\e24\Shared_E24\Stier\dershik\NV cluster\Coil_solidworks.step)
  id26.scale(2, 2, 1)
  id26.scale(4, 4, 1)
  id26.delete()
  coordinate_system FaceCS1 = face of id26: Origin=(626.73559mm, -362.73559mm, 0.33355445mm) FaceID=?.face(#14824) AxisPosn=(626.79424mm, -362.79424mm, 0.23231969mm) WhichAxis=X ZRotationAngle=0deg XOffset=0mm YOffset=0mm FaceNormal(0.70710678, 0.70710678, -3.4638242e-16)
  coordinate_system RelativeCS1 = origin=(0.8mm, 0mm, -0.16mm) x=(1mm, 0mm, 0mm) y=(0mm, 1mm, 0mm) in FaceCS1
  coordinate_system RelativeCS2 = origin=(0mm, 0mm, 0mm) x=(0.4mm, 0mm, 0mm) y=(0mm, 0mm, -0.4mm) in RelativeCS1
  coordinate_system NewCoordinateSystem = origin=(0mm, 0mm, 0mm) x=(0mm, 0mm, 1mm) y=(0.2mm, 0mm, 1.2mm) in RelativeCS2
  Rectangle1 [diamond, oriented by NewCoordinateSystem] = rectangle(corner=(-2mm, -3.5mm, 0mm), x_size=4mm, y_size=4mm) in FaceCS1
  Rectangle1.thicken(0.1mm)
  Region [vacuum, oriented by NewCoordinateSystem] = region(percentage_offset=20 on all sides) in FaceCS1
  Rectangle1.move(0.6mm, 1.8mm, 0mm) in FaceCS1
  Rectangle1.move(0.237526484mm, -0.0829mm, 1.3877788e-17mm) in FaceCS1
  0_2, 0_18..0_33 [gold, oriented by NewCoordinateSystem] = imported_body()
  0_2.move(0mm, -0.1mm, 0mm)
  0_18.move(0mm, -0.1mm, -0.5mm)
  [0_19..0_33].move(0mm, -0.1mm, 0mm)
  [0_2, 0_18..0_33].move(0.01mm, -0.04mm, 0mm)
  [0_2, 0_18..0_33].move(-0.02mm, 0mm, 0mm)
  [0_2, 0_18..0_33].move(0mm, 0mm, 0mm)
  [0_2, 0_18..0_33].move(0mm, 0.005mm, 0mm)
  [0_2, 0_18..0_33].move(0.002mm, -0.002mm, 0mm)
  [0_2, 0_18..0_33].move(-0.0006mm, 0.001mm, 0mm)
  [0_2, 0_18..0_33].move(-5e-05mm, 0.00015mm, 0mm)
  [0_2, 0_18..0_33].move(-1e-05mm, 2e-05mm, 0mm)
  [0_2, 0_18..0_33].move(5e-06mm, -1.5e-06mm, 0mm)
  0_2.move(0mm, 0mm, 0mm)
  0_18.move(0mm, 0mm, 0mm)
  0_19.move(0mm, 0mm, 0mm)
  0_20.move(0mm, 0mm, 0mm)
  0_21.move(0mm, 0mm, 0mm)
  0_22.move(0mm, 0mm, 0mm)
  0_23.move(0mm, 0mm, 0mm)
  0_24.move(0mm, 0mm, 0mm)
  0_25.move(0mm, 0mm, 0mm)
  0_26.move(0mm, 0mm, 0mm)
  0_27.move(0mm, 0mm, 0mm)
  0_28.move(0mm, 0mm, 0mm)
  0_29.move(0mm, 0mm, 0mm)
  0_30.move(0mm, 0mm, 0mm)
  0_31.move(0mm, 0mm, 0mm)
  0_32.move(0mm, 0mm, 0mm)
  0_33.move(0mm, 0mm, 0mm)
  0_2.move(0mm, 0mm, 0mm)
  0_18.move(0mm, 0mm, 0mm)
  0_19.move(0mm, 0mm, 0mm)
  0_20.move(0mm, 0mm, 0mm)
  0_21.move(0mm, 0mm, 0mm)
  0_22.move(0mm, 0mm, 0mm)
  0_23.move(0mm, 0mm, 0mm)
  0_24.move(0mm, 0mm, 0mm)
  0_25.move(0mm, 0mm, 0mm)
  0_26.move(0mm, 0mm, 0mm)
  0_27.move(0mm, 0mm, 0mm)
  0_28.move(0mm, 0mm, 0mm)
  0_29.move(0mm, 0mm, 0mm)
  0_30.move(0mm, 0mm, 0mm)
  0_31.move(0mm, 0mm, 0mm)
  0_32.move(0mm, 0mm, 0mm)
  0_33.move(0mm, 0mm, 0mm)
  0_2.move(0mm, 0mm, 0mm)
  0_18.move(0mm, 0mm, 0mm)
  0_19.move(0mm, 0mm, 0mm)
  0_20.move(0mm, 0mm, 0mm)
  0_21.move(0mm, 0mm, 0mm)
  0_22.move(0mm, 0mm, 0mm)
  0_23.move(0mm, 0mm, 0mm)
  0_24.move(0mm, 0mm, 0mm)
  0_25.move(0mm, 0mm, 0mm)
  0_26.move(0mm, 0mm, 0mm)
  0_27.move(0mm, 0mm, 0mm)
  0_28.move(0mm, 0mm, 0mm)
  0_29.move(0mm, 0mm, 0mm)
  0_30.move(0mm, 0mm, 0mm)
  0_31.move(0mm, 0mm, 0mm)
  0_32.move(0mm, 0mm, 0mm)
  0_33.move(0mm, 0mm, 0mm)
  0_2.move(0mm, 0mm, 0mm)
  0_18.move(0mm, 0mm, 0mm)
  0_19.move(0mm, 0mm, 0mm)
  0_20.move(0mm, 0mm, 0mm)
  0_21.move(0mm, 0mm, 0mm)
  0_22.move(0mm, 0mm, 0mm)
  0_23.move(0mm, 0mm, 0mm)
  0_24.move(0mm, 0mm, 0mm)
  0_25.move(0mm, 0mm, 0mm)
  0_26.move(0mm, 0mm, 0mm)
  0_27.move(0mm, 0mm, 0mm)
  0_28.move(0mm, 0mm, 0mm)
  0_29.move(0mm, 0mm, 0mm)
  0_30.move(0mm, 0mm, 0mm)
  0_31.move(0mm, 0mm, 0mm)
  0_32.move(0mm, 0mm, 0mm)
  0_33.move(0mm, 0mm, 0mm)
  [0_2, 0_18..0_33].move(0mm, 0mm, 0mm)
  [0_2, 0_18..0_33].move(-0.04mm, -0.11mm, 0mm)
  0_18.move(-0.40191747mm, -0.5632902mm, 0.23490959mm) in NewCoordinateSystem
  0_18.move(0.04mm, 0.18mm, 0mm) in NewCoordinateSystem
  0_18.move(-0.01mm, 0.02mm, 0mm) in NewCoordinateSystem
  0_18.move(0.045mm, -0.015mm, 0mm) in NewCoordinateSystem
  0_18.move(-0.002mm, 0.002mm, 0mm) in NewCoordinateSystem
  0_18.move(0.002mm, 0mm, 0mm) in NewCoordinateSystem
  0_18.move(-0.002mm, 0mm, 0mm) in NewCoordinateSystem
  0_18.move(0.001mm, 0mm, 0mm) in NewCoordinateSystem
  0_18.move(0mm, 0mm, 0mm) in NewCoordinateSystem
  0_18.move(-0.0004mm, -0.0002mm, 0mm) in NewCoordinateSystem
  0_18.move(0.0001mm, 0mm, 0mm) in NewCoordinateSystem
  0_18.move(-5e-05mm, 5e-05mm, 0mm) in NewCoordinateSystem
  0_18.move(0.18mm, 0.43mm, 0mm) in NewCoordinateSystem
  0_18.move(0mm, 0.005mm, 0mm) in NewCoordinateSystem
  0_18.move(-0.002mm, -0.002mm, 0mm) in NewCoordinateSystem
  0_18.move(-0.002mm, 0mm, 0mm) in NewCoordinateSystem
  0_18.move(0.002mm, 0mm, 0mm) in NewCoordinateSystem
  0_18.move(0mm, 0mm, 0mm) in NewCoordinateSystem
  0_18.move(-0.0002mm, 0.0002mm, 0mm) in NewCoordinateSystem
  0_18.move(-5e-05mm, 0.00015mm, 0mm) in NewCoordinateSystem
  0_18.move(-4e-06mm, -4e-06mm, 0mm) in NewCoordinateSystem
  0_18.move(0mm, 0mm, 0mm) in NewCoordinateSystem
  0_18.move(-0.22mm, -0.46mm, 0mm) in NewCoordinateSystem
  0_18.move(-0.002mm, 0.002mm, 0mm) in NewCoordinateSystem
  0_18.move(0mm, 0mm, 0mm) in NewCoordinateSystem
  0_18.move(-0.001mm, 0mm, 0mm) in NewCoordinateSystem
  0_18.move(-0.0005mm, -0.0005mm, 0mm) in NewCoordinateSystem
  0_18.move(0.0003mm, 0mm, 0mm) in NewCoordinateSystem
  0_18.move(0mm, 0.0001mm, 0mm) in NewCoordinateSystem
  0_18.move(-0.005mm, 0.04mm, 0mm) in NewCoordinateSystem
  0_18.move(-0.004mm, 0.002mm, 0mm) in NewCoordinateSystem
  group Group3 = 0_2, 0_18..0_33
